# Ansys Electronics Desktop project, version 2020.1
project variables:
  $dirt_width = 0.1mm
  $cav_maj_rad = 16.8mm
  $cav_ratio = 5/3
  $cav_min_rad = $cav_maj_rad*$cav_ratio
materials:
  vacuum: permittivity=1

design full cav (HFSS, Eigenmode, model units mm)
variables:
  cav_major_rad = $cav_maj_rad
  cav_ratio = $cav_ratio
  dirt_width = $dirt_width
  cav_maj_rad = $cav_maj_rad
geometry:
  cavity [vacuum] = ellipse(normal=Z, centre=(0mm, 0mm, 0mm), major_radius=cav_maj_rad, ratio=cav_ratio)
  Rectangle3 = rectangle(corner=(0mm, -$cav_min_rad-0.5, 0mm), x_size=-18mm, y_size=2*$cav_min_rad+1)
  cavity.intersect(Rectangle3)
  cavity.sweep_around_axis(axis=Y, angle=360deg)
  dirt [vacuum] = ellipse(normal=Z, centre=(0mm, 0mm, 0mm), major_radius=cav_maj_rad, ratio=cav_ratio)
  Rectangle4 = rectangle(corner=(0mm, -$cav_min_rad-0.5, 0mm), x_size=-18mm, y_size=2*$cav_min_rad+1)
  dirt.intersect(Rectangle4)
  dirt.sweep_around_axis(axis=Y, angle=360deg)
  cav_inside = ellipse(normal=Z, centre=(0mm, 0mm, 0mm), major_radius=cav_maj_rad, ratio=cav_ratio)
  Rectangle5 = rectangle(corner=(0mm, -$cav_min_rad-0.5, 0mm), x_size=-18mm, y_size=2*$cav_min_rad+1)
  cav_inside.intersect(Rectangle5)
  cav_inside.sweep_around_axis(axis=Y, angle=360deg)
  cav_inside.move_faces(MoveAlongNormalFlag=true OffsetDistance=-dirt_width FacesToMove=cav_inside.face(#3163))
  dirt.subtract(cav_inside)
setups:
  setup: HfssEigen MinimumFrequency=2GHz NumModes=1 MaxDeltaFreq=0.02 ConvergeOnRealFreq=true MaximumPasses=12 MinimumPasses=2 MinimumConvergedPasses=2 PercentRefinement=30 BasisOrder=-1
source amplitudes:
  #-10:1: 1 0deg

design half cav (HFSS, Eigenmode, model units mm)
variables:
  cav_maj_rad = $cav_maj_rad
  cav_ratio = $cav_ratio
  dirt_width = $dirt_width
geometry:
  dirt [vacuum] = ellipse(normal=Z, centre=(0mm, 0mm, 0mm), major_radius=cav_maj_rad, ratio=cav_ratio)
  Rectangle4 = rectangle(corner=(0mm, 0mm, 0mm), x_size=-18mm, y_size=28mm)
  dirt.intersect(Rectangle4)
  dirt.sweep_around_axis(axis=Y, angle=360deg)
  cav_inside = ellipse(normal=Z, centre=(0mm, 0mm, 0mm), major_radius=cav_maj_rad, ratio=cav_ratio)
  Rectangle5 = rectangle(corner=(0mm, 0mm, 0mm), x_size=-18mm, y_size=28mm)
  cav_inside.intersect(Rectangle5)
  cav_inside.sweep_around_axis(axis=Y, angle=360deg)
  cav_inside.move_faces(MoveAlongNormalFlag=true OffsetDistance=-dirt_width FacesToMove=cav_inside.face(all 2))
  dirt.subtract(cav_inside)
  cavity [vacuum] = ellipse(normal=Z, centre=(0mm, 0mm, 0mm), major_radius=cav_maj_rad, ratio=cav_ratio)
  Rectangle3 = rectangle(corner=(0mm, 0mm, 0mm), x_size=-18mm, y_size=28mm)
  cavity.intersect(Rectangle3)
  cavity.sweep_around_axis(axis=Y, angle=360deg)
setups:
  setup: HfssEigen MinimumFrequency=2GHz NumModes=1 MaxDeltaFreq=0.02 ConvergeOnRealFreq=true MaximumPasses=12 MinimumPasses=2 MinimumConvergedPasses=2 PercentRefinement=30 BasisOrder=-1
source amplitudes:
  #-10:1: 1 0deg
