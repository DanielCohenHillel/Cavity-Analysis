# Ansys Electronics Desktop project, version 2020.1
project variables:
  $B = 0.6
  $Lj = 8nH
  $taper_L = 1.5mm
  $taper_w = 0.55mm
  $coax_r = 2mm
  $coax_L = 2.4cm
  $pickup_r = 0.8cm
  $pickup_L = 4cm
  $chip_thickness = 0.1mm
  $chip_w = 2mm
  $cav_r = 2.8cm
  $ro_L = 10mm
  $ro_w = 0.15mm
  $jj_w = 4um
  $jj_L = 10um
  $pad_w = 700um
  $pad_L = 350um
  $lead_w = 20um
  $lead_L = 105um
  $ro_gap = 2mm
  $antenna_R = 0.2mm
  $antenna_w = 0.1mm
  $antenna_L = 1.75mm
  $antenna_depth = -0.6mm
  $chip_penetration = -0.15mm
  $roHoleDepth = 200mil
  $roHoleRadius = 57.5mil
  $roPinPos = 9.5mm
  $outPinLength = 0.9mm
  $seam_dist = 6.5mm
  $chip2_thickness = 0.43mm
materials:
  perfect conductor: conductivity=1e+30
  sapphire: permittivity=10
  vacuum: permittivity=1

design design (HFSS, Eigenmode, model units mm)
variables:
  B = 0.6
  Lj_1 = 8nH
  taper_l = 1.5mm
  taper_w = 0.55mm
  coax_r = 2mm
  coax_L = 2.4cm
  pickup_r = 0.8cm
  pickup_L = 4cm
  chip_thickness = 0.1mm
  chip_w = 2mm
  cav_R = 2.8cm
  ro_L = 10mm
  ro_w = 0.15mm
  jj_w = 4um
  jj_L = 10um
  pad_w = 700um
  pad_L = 350um
  lead_w = 20um
  leads_L = 105um
  ro_gap = 2mm
  antenna_r = 0.2mm
  antenna_w = 0.1mm
  antenna_L = 1.75mm
  antenna_depth = -0.6mm
  chip_penetration = -0.15mm
  roHoleDepth = 200mil
  roHoleRadius = 57.5mil
  roPinPos = 9.5mm
  outPinLength = 0.9mm
  seam_dist = 6.5mm
  chip2_thickness = 0.43mm
geometry:
  Ellipse2 = ellipse(normal=X, centre=(0mm, 0mm, 0mm), major_radius=cav_R, ratio=b)
  Rectangle2 = rectangle(corner=(0mm, 0mm, 0mm), y_size=10*cav_R, z_size=-10*cav_R)
  Cavity = rectangle(corner=(0mm, 0mm, 0mm), y_size=coax_r, z_size=coax_L)
  cavity_1 = rectangle(corner=(0mm, 0mm, 0mm), y_size=pickup_r, z_size=-pickup_L)
  chip = box(corner=(-chip_thickness/2, -chip_w/2, coax_L), size=(chip_thickness, chip_w, -coax_L-chip_penetration))
  Circle1 = circle(normal=X, centre=(-chip_thickness/2, 0mm, -antenna_depth), radius=antenna_r)
  Rectangle5 = rectangle(corner=(-chip_thickness/2, -antenna_w /2, -antenna_depth), y_size=antenna_w, z_size=antenna_L)
  pad_antenna = rectangle(corner=(-chip_thickness/2, -pad_w/2, antenna_L-antenna_depth), y_size=pad_w, z_size=pad_L)
  Rectangle7 = rectangle(corner=(-chip_thickness/2, -lead_w /2, antenna_L+pad_L-antenna_depth), y_size=lead_w, z_size=leads_L)
  pad_antenna.unite(Rectangle5, Circle1, Rectangle7)
  rect_jj1 = rectangle(corner=(-chip_thickness/2, -jj_w /2, antenna_L+pad_L+leads_L-antenna_depth), y_size=jj_w, z_size=jj_L)
  Rectangle9 = rectangle(corner=(-chip_thickness/2, -lead_w/2, antenna_L-antenna_depth+pad_L+leads_L+jj_L), y_size=lead_w, z_size=leads_L)
  pad = rectangle(corner=(-chip_thickness/2, -pad_w /2, antenna_L+pad_L+2*leads_L+jj_L-antenna_depth), y_size=pad_w, z_size=pad_L)
  pad.unite(Rectangle9)
  readout = rectangle(corner=(-chip_thickness/2, -ro_w/2, antenna_L+2*pad_L+2*leads_L+jj_L-antenna_depth+ro_gap), y_size=ro_w, z_size=ro_L)
  line_jj1 = polyline((-chip_thickness/2, 0, antenna_L+leads_L+pad_L-antenna_depth) (-chip_thickness/2, 0, antenna_L+leads_L+pad_L-antenna_depth+jj_L))
  chip1 = box(corner=(-chip_thickness/2, chip_w/2, taper_l-chip_penetration), size=(chip_thickness, -taper_w, -taper_l))
  chip2 = box(corner=(-chip_thickness/2, -chip_w/2, taper_l-chip_penetration), size=(chip_thickness, taper_w, -taper_l))
  chip.subtract(chip1, chip2)
  Ellipse2.intersect(Rectangle2)
  cavity_1.unite(Ellipse2, Cavity)
  cavity_1.sweep_around_axis(axis=Z, angle=360deg)
  outPin [perfect conductor] = cylinder(axis=Y, base_centre=(0, -coax_r-roHoleDepth, roPinPos), radius=25mil, height=(roHoleDepth - outPinLength))
  cavity_2 [vacuum] = cylinder(axis=Y, base_centre=(0, -coax_r-roHoleDepth, roPinPos), radius=roHoleRadius, height=roHoleDepth+1mm)
  cavity_2.unite(cavity_1)
  seam = polyline((coax_r, 0mm, seam_dist) (-2mm, 1.7453293e-05mm, 6.5mm) (2mm, -3.4906585e-05mm, 6.5mm), AngularArc from point 0 over 3 centre=(0mm, 0mm, seam_dist) angle=359.999deg plane=XY)
  chip_holder = box(corner=(-chip_thickness/2, -chip_w/2, coax_L), size=(-chip2_thickness, chip_w, -coax_L-chip_penetration+taper_l))
  chip.unite(chip_holder)
  chip_holder1 = box(corner=(-chip_thickness/2, -chip_w/2, coax_L), size=(-chip2_thickness, chip_w, -coax_L-chip_penetration+taper_l))
  chip.unite(chip_holder1)
  chip_holder2 [sapphire] = box(corner=(-chip_thickness/2, -chip_w/2, coax_L), size=(-chip2_thickness, chip_w, -coax_L-chip_penetration+taper_l))
  chip_holder2.unite(chip)
boundaries and excitations:
  C1_PerfE: Perfect E Objects=pad
  C2_PerfE1: Perfect E Objects=pad_antenna
  L_lumpLRC: Lumped RLC Objects=rect_jj1 CurrentLine{middle of rect_jj1.edge(z opposite corner) -> middle of rect_jj1.edge(z at corner)} Inductance=Lj_1
  ro_PerfE1: Perfect E Objects=readout
  output_coupler: Lumped RLC Faces=cavity_2.face(2 of 3) CurrentLine{outPin.vertex(1 of 2) -> cavity_2.vertex(1 of 2)} Resistance=50ohm
mesh:
  junction: LengthBased Objects=rect_jj1 MaxLength=4um
  readout: LengthBased Objects=readout MaxLength=0.1mm
  transmon: LengthBased Objects=[pad_antenna, pad] MaxLength=0.1mm
setups:
  Setup1: HfssEigen MinimumFrequency=4GHz NumModes=5 MaxDeltaFreq=2 ConvergeOnRealFreq=true MaximumPasses=3 MinimumPasses=3 MinimumConvergedPasses=2 PercentRefinement=30 BasisOrder=-1
source amplitudes:
  #-10:1..#-10:4: 0 0
  #-10:5: 1 0
reports:
  Freq. vs. pass: re(Mode(1)), re(Mode(2)), re(Mode(3)), re(Mode(4)), re(Mode(5)) vs Pass on Setup1 : AdaptivePass
