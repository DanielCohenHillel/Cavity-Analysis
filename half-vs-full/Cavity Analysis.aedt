# Ansys Electronics Desktop project, version 2020.1
project variables:
  $dirt_width = -1mm
  $cav_maj_rad = 30mm
  $cav_ratio = 1/2
  $cav_min_rad = $cav_maj_rad*$cav_ratio
materials:
  vacuum: permittivity=1
  plexiglass: permittivity=3.4 dielectric_loss_tangent=0.001
  conformal_coat: permittivity=3.1 permeability=1 dielectric_loss_tangent=0.035
  modified_epoxy: permittivity=4.2 dielectric_loss_tangent=0.02

design full cav (HFSS, Eigenmode, model units mm)
variables:
  cav_major_rad = $cav_maj_rad
  cav_ratio = $cav_ratio
  dirt_width = $dirt_width
  cav_maj_rad = $cav_maj_rad
geometry:
  cavity [vacuum] = ellipse(normal=Z, centre=(0mm, 0mm, 0mm), major_radius=cav_maj_rad, ratio=cav_ratio)
  Rectangle3 = rectangle(corner=(0mm, -$cav_min_rad-0.5, 0mm), x_size=-2*$cav_min_rad-1, y_size=2*$cav_min_rad+1)
  cavity.intersect(Rectangle3)
  cavity.sweep_around_axis(axis=Y, angle=360deg)
  cavity1 = ellipse(normal=Z, centre=(0mm, 0mm, 0mm), major_radius=cav_maj_rad, ratio=cav_ratio)
  Rectangle4 = rectangle(corner=(0mm, -$cav_min_rad-0.5, 0mm), x_size=-2*$cav_min_rad-1, y_size=2*$cav_min_rad+1)
  cavity1.intersect(Rectangle4)
  cavity1.sweep_around_axis(axis=Y, angle=360deg)
  dirt [modified_epoxy] = ellipse(normal=Z, centre=(0mm, 0mm, 0mm), major_radius=cav_maj_rad, ratio=cav_ratio)
  Rectangle5 = rectangle(corner=(0mm, -$cav_min_rad-0.5, 0mm), x_size=-2*$cav_min_rad-1, y_size=2*$cav_min_rad+1)
  dirt.intersect(Rectangle5)
  dirt.sweep_around_axis(axis=Y, angle=360deg)
  dirt.move_faces(MoveAlongNormalFlag=true OffsetDistance=-dirt_width FacesToMove=dirt.face(#3308))
  dirt.subtract(cavity1)
setups:
  setup: HfssEigen MinimumFrequency=2GHz NumModes=1 MaxDeltaFreq=0.01 ConvergeOnRealFreq=true MaximumPasses=12 MinimumPasses=2 MinimumConvergedPasses=2 PercentRefinement=30 BasisOrder=-1
source amplitudes:
  #-10:1: 1 0deg

design half cav (HFSS, Eigenmode, model units mm)
variables:
  cav_maj_rad = $cav_maj_rad
  cav_ratio = $cav_ratio
  dirt_width = $dirt_width
geometry:
  cavity [vacuum] = ellipse(normal=Z, centre=(0mm, 0mm, 0mm), major_radius=cav_maj_rad, ratio=cav_ratio)
  Rectangle3 = rectangle(corner=(0mm, 0mm, 0mm), x_size=-2*$cav_maj_rad-1, y_size=2*$cav_min_rad+1)
  cavity.intersect(Rectangle3)
  cavity.sweep_around_axis(axis=Y, angle=360deg)
  cavity1 = ellipse(normal=Z, centre=(0mm, 0mm, 0mm), major_radius=cav_maj_rad, ratio=cav_ratio)
  Rectangle4 = rectangle(corner=(0mm, 0mm, 0mm), x_size=-2*$cav_maj_rad-1, y_size=2*$cav_min_rad+1)
  cavity1.intersect(Rectangle4)
  cavity1.sweep_around_axis(axis=Y, angle=360deg)
  dirt [modified_epoxy] = ellipse(normal=Z, centre=(0mm, 0mm, 0mm), major_radius=cav_maj_rad, ratio=cav_ratio)
  Rectangle5 = rectangle(corner=(0mm, 0mm, 0mm), x_size=-2*$cav_maj_rad-1, y_size=2*$cav_min_rad+1)
  dirt.intersect(Rectangle5)
  dirt.sweep_around_axis(axis=Y, angle=360deg)
  dirt.move_faces(MoveAlongNormalFlag=true OffsetDistance=-dirt_width FacesToMove=dirt.face(#1852, #1853))
  dirt.subtract(cavity1)
setups:
  setup: HfssEigen MinimumFrequency=2GHz NumModes=1 MaxDeltaFreq=0.01 ConvergeOnRealFreq=true MaximumPasses=12 MinimumPasses=2 MinimumConvergedPasses=2 PercentRefinement=30 BasisOrder=-1
source amplitudes:
  #-10:1: 1 0deg
